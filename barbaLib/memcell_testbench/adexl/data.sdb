ADE simulation setup
Run mode: Single Run, Sweeps and Corners
Tests:
  barbaLib:memcell_testbench:1: barbaLib/memcell_testbench/schematic, simulator spectre
Global variables:
  R2 = 5k
  R1 = 5
  vdd = 1.8
  T = 20u
  vin = 1
  cap = 10p
