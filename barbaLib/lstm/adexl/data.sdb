ADE simulation setup
Run mode: Single Run, Sweeps and Corners
Tests:
  barbaLib:lstm:1: barbaLib/lstm/schematic, simulator spectre
Global variables:
  R3 = 50k
  R1 = 50k
  Rf = 505k
  R2 = 500k
  R4 = 500k
  R = 505k
  T = 40us
  vdd = 1.8
  in0step0 = 1.5
  in0step1 = 2.3m
