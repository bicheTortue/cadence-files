ADE simulation setup
Run mode: Single Run, Sweeps and Corners
Tests:
  barbaLib:opAmp_gain:1: barbaLib/opAmp_gain/schematic, simulator spectre
