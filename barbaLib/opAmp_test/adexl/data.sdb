ADE simulation setup
Run mode: Single Run, Sweeps and Corners
Tests:
  barbaLib:opAmp_test:1: barbaLib/opAmp_test/schematic, simulator spectre
Global variables:
  vin = 1
  vdd = 1.2
