ADE simulation setup
Run mode: Single Run, Sweeps and Corners
Tests:
  barbaLib:tanh_test:1: barbaLib/tanh_test/schematic, simulator spectre
Global variables:
  vdd = 1.8
  v3 = .8
  v2 = .635
  v1 = 1.1
  vin = 0
  vin1 = .9
  vin0 = .98
  idc = 150u
