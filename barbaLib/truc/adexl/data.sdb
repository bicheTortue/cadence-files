ADE simulation setup
Run mode: Single Run, Sweeps and Corners
Tests:
  barbaLib:truc:1: barbaLib/truc/schematic, simulator spectre
    Outputs: outputVal
Global variables:
  R3 = 50k
  R1 = 50k
  Rf = 505k
  R2 = 500k
  R4 = 500k
  R = 505k
  T = 8u
  vdd = 1.8
  in0step0 = 0.0015 (off)
  in0step1 = 0.0027 (off)
  step = 100 (off)
  x = axis
  V3t = 550m
  V2 = 0.635
  V1 = 1.1
  V3s = 800m
  r = 10
Corners (nominal off):
  test0: in0step0=0.0015; in0step1=0.0027; step=0
  test1: in0step0=0.0027; in0step1=0.0054; step=1
  test2: in0step0=0.0054; in0step1=0.0048; step=2
  test3: in0step0=0.0048; in0step1=0.0033; step=3
  test4: in0step0=0.0033; in0step1=0.006; step=4
  test5: in0step0=0.006; in0step1=0.0085; step=5
  test6: in0step0=0.0085; in0step1=0.0085; step=6
  test7: in0step0=0.0085; in0step1=0.0062; step=7
  test8: in0step0=0.0062; in0step1=0.0029; step=8
  test9: in0step0=0.0029; in0step1=0.0; step=9
  test10: in0step0=0.0; in0step1=0.0027; step=10
  test11: in0step0=0.0027; in0step1=0.0021; step=11
  test12: in0step0=0.0021; in0step1=0.0042; step=12
  test13: in0step0=0.0042; in0step1=0.0071; step=13
  test14: in0step0=0.0071; in0step1=0.006; step=14
  test15: in0step0=0.006; in0step1=0.0041; step=15
  test16: in0step0=0.0041; in0step1=0.0087; step=16
  test17: in0step0=0.0087; in0step1=0.013; step=17
  test18: in0step0=0.013; in0step1=0.013; step=18
  test19: in0step0=0.013; in0step1=0.01; step=19
  test20: in0step0=0.01; in0step1=0.0056; step=20
  test21: in0step0=0.0056; in0step1=0.0019; step=21
  test22: in0step0=0.0019; in0step1=0.0069; step=22
  test23: in0step0=0.0069; in0step1=0.0079; step=23
  test24: in0step0=0.0079; in0step1=0.0089; step=24
  test25: in0step0=0.0089; in0step1=0.014; step=25
  test26: in0step0=0.014; in0step1=0.011; step=26
  test27: in0step0=0.011; in0step1=0.013; step=27
  test28: in0step0=0.013; in0step1=0.014; step=28
  test29: in0step0=0.014; in0step1=0.018; step=29
  test30: in0step0=0.018; in0step1=0.018; step=30
  test31: in0step0=0.018; in0step1=0.015; step=31
  test32: in0step0=0.015; in0step1=0.011; step=32
  test33: in0step0=0.011; in0step1=0.0081; step=33
  test34: in0step0=0.0081; in0step1=0.012; step=34
  test35: in0step0=0.012; in0step1=0.013; step=35
  test36: in0step0=0.013; in0step1=0.015; step=36
  test37: in0step0=0.015; in0step1=0.017; step=37
  test38: in0step0=0.017; in0step1=0.015; step=38
  test39: in0step0=0.015; in0step1=0.015; step=39
  test40: in0step0=0.015; in0step1=0.022; step=40
  test41: in0step0=0.022; in0step1=0.024; step=41
  test42: in0step0=0.024; in0step1=0.027; step=42
  test43: in0step0=0.027; in0step1=0.02; step=43
  test44: in0step0=0.02; in0step1=0.017; step=44
  test45: in0step0=0.017; in0step1=0.013; step=45
  test46: in0step0=0.013; in0step1=0.017; step=46
  test47: in0step0=0.017; in0step1=0.018; step=47
  test48: in0step0=0.018; in0step1=0.018; step=48
  test49: in0step0=0.018; in0step1=0.025; step=49
  test50: in0step0=0.025; in0step1=0.025; step=50
  test51: in0step0=0.025; in0step1=0.024; step=51
  test52: in0step0=0.024; in0step1=0.027; step=52
  test53: in0step0=0.027; in0step1=0.031; step=53
  test54: in0step0=0.031; in0step1=0.032; step=54
  test55: in0step0=0.032; in0step1=0.026; step=55
  test56: in0step0=0.026; in0step1=0.021; step=56
  test57: in0step0=0.021; in0step1=0.015; step=57
  test58: in0step0=0.015; in0step1=0.019; step=58
  test59: in0step0=0.019; in0step1=0.019; step=59
  test60: in0step0=0.019; in0step1=0.016; step=60
  test61: in0step0=0.016; in0step1=0.025; step=61
  test62: in0step0=0.025; in0step1=0.024; step=62
  test63: in0step0=0.024; in0step1=0.025; step=63
  test64: in0step0=0.025; in0step1=0.031; step=64
  test65: in0step0=0.031; in0step1=0.038; step=65
  test66: in0step0=0.038; in0step1=0.036; step=66
  test67: in0step0=0.036; in0step1=0.03; step=67
  test68: in0step0=0.03; in0step1=0.024; step=68
  test69: in0step0=0.024; in0step1=0.019; step=69
  test70: in0step0=0.019; in0step1=0.024; step=70
  test71: in0step0=0.024; in0step1=0.027; step=71
  test72: in0step0=0.027; in0step1=0.025; step=72
  test73: in0step0=0.025; in0step1=0.031; step=73
  test74: in0step0=0.031; in0step1=0.032; step=74
  test75: in0step0=0.032; in0step1=0.032; step=75
  test76: in0step0=0.032; in0step1=0.041; step=76
  test77: in0step0=0.041; in0step1=0.05; step=77
  test78: in0step0=0.05; in0step1=0.047; step=78
  test79: in0step0=0.047; in0step1=0.04; step=79
  test80: in0step0=0.04; in0step1=0.033; step=80
  test81: in0step0=0.033; in0step1=0.026; step=81
  test82: in0step0=0.026; in0step1=0.034; step=82
  test83: in0step0=0.034; in0step1=0.035; step=83
  test84: in0step0=0.035; in0step1=0.033; step=84
  test85: in0step0=0.033; in0step1=0.041; step=85
  test86: in0step0=0.041; in0step1=0.04; step=86
  test87: in0step0=0.04; in0step1=0.041; step=87
  test88: in0step0=0.041; in0step1=0.052; step=88
  test89: in0step0=0.052; in0step1=0.06; step=89
  test90: in0step0=0.06; in0step1=0.058; step=90
  test91: in0step0=0.058; in0step1=0.048; step=91
  test92: in0step0=0.048; in0step1=0.039; step=92
  test93: in0step0=0.039; in0step1=0.032; step=93
  test94: in0step0=0.032; in0step1=0.039; step=94
  test95: in0step0=0.039; in0step1=0.041; step=95
  test96: in0step0=0.041; in0step1=0.038; step=96
  test97: in0step0=0.038; in0step1=0.049; step=97
  test98: in0step0=0.049; in0step1=0.047; step=98
  test99: in0step0=0.047; in0step1=0.048; step=99
  test100: in0step0=0.048; in0step1=0.061; step=100
  test101: in0step0=0.061; in0step1=0.07; step=101
  test102: in0step0=0.07; in0step1=0.07; step=102
  test103: in0step0=0.07; in0step1=0.058; step=103
  test104: in0step0=0.058; in0step1=0.047; step=104
  test105: in0step0=0.047; in0step1=0.039; step=105
  test106: in0step0=0.039; in0step1=0.045; step=106
  test107: in0step0=0.045; in0step1=0.046; step=107
  test108: in0step0=0.046; in0step1=0.041; step=108
  test109: in0step0=0.041; in0step1=0.05; step=109
  test110: in0step0=0.05; in0step1=0.047; step=110
  test111: in0step0=0.047; in0step1=0.05; step=111
  test112: in0step0=0.05; in0step1=0.064; step=112
  test113: in0step0=0.064; in0step1=0.075; step=113
  test114: in0step0=0.075; in0step1=0.077; step=114
  test115: in0step0=0.077; in0step1=0.058; step=115
  test116: in0step0=0.058; in0step1=0.049; step=116
  test117: in0step0=0.049; in0step1=0.04; step=117
  test118: in0step0=0.04; in0step1=0.045; step=118
  test119: in0step0=0.045; in0step1=0.049; step=119
  test120: in0step0=0.049; in0step1=0.046; step=120
  test121: in0step0=0.046; in0step1=0.058; step=121
  test122: in0step0=0.058; in0step1=0.056; step=122
  test123: in0step0=0.056; in0step1=0.061; step=123
  test124: in0step0=0.061; in0step1=0.071; step=124
  test125: in0step0=0.071; in0step1=0.086; step=125
  test126: in0step0=0.086; in0step1=0.088; step=126
  test127: in0step0=0.088; in0step1=0.069; step=127
  test128: in0step0=0.069; in0step1=0.058; step=128
  test129: in0step0=0.058; in0step1=0.05; step=129
  test130: in0step0=0.05; in0step1=0.058; step=130
  test131: in0step0=0.058; in0step1=0.06; step=131
  test132: in0step0=0.06; in0step1=0.055; step=132
  test133: in0step0=0.055; in0step1=0.061; step=133
  test134: in0step0=0.061; in0step1=0.069; step=134
  test135: in0step0=0.069; in0step1=0.071; step=135
  test136: in0step0=0.071; in0step1=0.083; step=136
  test137: in0step0=0.083; in0step1=0.1; step=137
  test138: in0step0=0.1; in0step1=0.097; step=138
  test139: in0step0=0.097; in0step1=0.078; step=139
  test140: in0step0=0.078; in0step1=0.069; step=140
  test141: in0step0=0.069; in0step1=0.055; step=141
