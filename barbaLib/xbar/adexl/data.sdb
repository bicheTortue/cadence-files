ADE simulation setup
Run mode: Single Run, Sweeps and Corners
Tests:
  barbaLib:xbar:1: barbaLib/xbar/schematic, simulator spectre
Global variables:
  Rf = 505k
  R = 505k
  T = 40us
  in0step0 = 0.02
  in0step1 = -30m
  in1step0 = -30m
  in1step1 = 50m
  vdd = 1.8
