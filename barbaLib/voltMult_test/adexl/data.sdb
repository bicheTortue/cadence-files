ADE simulation setup
Run mode: Single Run, Sweeps and Corners
Tests:
  barbaLib:voltMult_test:1: barbaLib/voltMult_test/schematic, simulator spectre
Global variables:
  vin1step0 = 0.5
  vin1step1 = 0.2
  T = 40u
  vin0step0 = 1
  vin0step1 = 0.5
  vdd = 1.8
