ADE simulation setup
Run mode: Single Run, Sweeps and Corners
Tests:
  barbaLib:allG:1: barbaLib/allG/schematic, simulator spectre
Global variables:
  Rf = 505k
  R = 505k
  vdd = 1.8
  T = 40us
  in0step0 = 1.5m
  in0step1 = 2.3m
