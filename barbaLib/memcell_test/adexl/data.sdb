ADE simulation setup
Run mode: Single Run, Sweeps and Corners
Tests:
  barbaLib:memcell_test:1: barbaLib/memcell_test/schematic, simulator spectre
Global variables:
  vdd = 1.8
  T = 40u
  vin = 1
