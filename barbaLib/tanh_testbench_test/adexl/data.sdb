ADE simulation setup
Run mode: Single Run, Sweeps and Corners
Tests:
  barbaLib:tanh_testbench_test:1: barbaLib/tanh_testbench_test/schematic, simulator spectre
