ADE simulation setup
Run mode: Single Run, Sweeps and Corners
Tests:
  barbaLib:sigmoid_testbench:1: barbaLib/sigmoid_testbench/schematic, simulator spectre
Global variables:
  lambda = .2
  R = 5k
  l = 60n
  w = 900n
  V3 = 800m
  V2 = .635
  V1 = 1.1
  vdd = 1.8
  Vin = .9
  idc = 250n
