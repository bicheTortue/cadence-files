// Data saver for offset measurement of comparator

`include "constants.vams"
`include "disciplines.vams"

module analog_data_saver (vin, clk)  ;

   input vin;
   electrical vin;
   input clk;
   electrical clk;

   parameter real threshold  = 0.25;
   parameter string filename = "a.csv";
   parameter string filemode = "w";
   real flag;

   integer file;

   analog
     begin
        @(initial_step)
	  begin
             file  = $fopen(filename,filemode);
	     $fwrite(file,"#format table ## [WaveView Analyzer] saved \nXVAL ,VIN\n");
	  end

        @(cross( (V(clk) - threshold) , +1))
	  begin
	    	  $fwrite(file, "%0.18f, %0.9f\n",$abstime, V(vin));
		  $fclose(file);
		  flag	= 1;
	    end
     end

endmodule
